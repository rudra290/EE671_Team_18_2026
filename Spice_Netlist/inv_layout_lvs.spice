* NGSPICE file created from invX1.ext - technology: sky130A

.subckt invX1 vin Vdd Vss vout
X0 vout vin Vdd Vdd sky130_fd_pr__pfet_01v8 ad=0.378 pd=3.12 as=0.378 ps=3.12 w=1.26 l=0.15
X1 vout vin Vss Vss sky130_fd_pr__nfet_01v8 ad=0.126 pd=1.44 as=0.126 ps=1.44 w=0.42 l=0.15
.ends
