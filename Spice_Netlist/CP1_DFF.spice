.lib /foss/pdks/sky130A/libs.tech/ngspice/sky130.lib.spice tt

.subckt INVX1 in vdd vss out
xm01 out in vdd vdd sky130_fd_pr__pfet_01v8 l=0.15 w=1.26 as='w * 2 * l' ad='w * 2 * l' ps='2 * (w + (2*l))' pd='2 * (w + (2*l))'
xm02 out in vss vss sky130_fd_pr__nfet_01v8 l=0.15 w=0.42 as='w * 2 * l' ad='w * 2 * l' ps='2 * (w + (2*l))' pd='2 * (w + (2*l))'
.ends INVX1

.subckt TG in n_in out p_in vdd vss
xm01 in n_in out vss sky130_fd_pr__nfet_01v8 l=0.15 w=0.42 as='w * 2 * l' ad='w * 2 * l' ps='2 * (w + (2*l))' pd='2 * (w + (2*l))'
xm02 out p_in in vdd sky130_fd_pr__pfet_01v8 l=0.15 w=1.26 as='w * 2 * l' ad='w * 2 * l' ps='2 * (w + (2*l))' pd='2 * (w + (2*l))'
.ends TG

*Circuit
V_dd vdd 0 DC 1.8
V_D in 0 		PULSE(0 1.8 0 10p 10p 10n 20n)
V_CLK clk 0 		PULSE(0 1.8 1n 10p 10p 10n 20n)
V_CLK_bar clk_bar 0 	PULSE(1.8 0 1n 10p 10p 10n 20n)

*Master (+ve Latch)
X_Inv_A in vdd 0 A_out			INVX1
X_TG_B 	A_out clk B_out clk_bar vdd 0 	TG
X_Inv_C B_out vdd 0 C_out		INVX1
X_Inv_D C_out vdd 0 D_out		INVX1
X_TG_E	D_out clk_bar B_out clk vdd 0	TG

*Slave (-ve Latch)
X_TG_F	C_out clk_bar F_out clk vdd 0	TG
X_Inv_G F_out vdd 0 G_out		INVX1
X_Inv_H	G_out vdd 0 H_out		INVX1
X_TG_I 	H_out clk F_out clk_bar vdd 0	TG
X_Inv_J	G_out vdd 0 Q			INVX1

*Load (Used just to simulate an actual load)
;C_Load Q 0 0.5f
X_Inv_Load Q vdd 0 load_out		INVX1

.tran 1p 22n

.control
run
plot v(in) v(Q) v(A_out) v(clk)
plot v(A_out) v(B_out) v(C_out) v(D_out)
plot v(F_out) v(G_out) v(H_out) v(Q)
.endc
