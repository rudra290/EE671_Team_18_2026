* Golden transistor-level schematic for Inverter_X1 LVS

.subckt Inverter_X1 vin Vdd Vss vout
XMP vout vin Vdd Vdd sky130_fd_pr__pfet_01v8 w=1.26 l=0.15
XMN vout vin Vss Vss sky130_fd_pr__nfet_01v8 w=0.42 l=0.15
.ends Inverter_X1
